parameters Ndiscmin0 = 0.006300010092931419 Ndiscmin1 = 0.010619177441331458 Ndiscmin2 = 0.007312593359473839 Ndiscmin3 = 0.004354369707201749 Ndiscmin4 = 0.011843002830809465 Ndiscmin5 = 0.007637299032704417 Ndiscmin6 = 0.006699770593613315 Ndiscmin7 = 0.010663749775748722 Ndiscmin8 = 0.00797031656293161 Ndiscmin9 = 0.006304360686804549 Ndiscmin10 = 0.005828348742028127 Ndiscmin11 = 0.0060086338582895525 Ndiscmin12 = 0.009547680201400875 Ndiscmin13 = 0.00786378909609384 Ndiscmin14 = 0.0076696640516881204 Ndiscmin15 = 0.0061160631101307905 Ndiscmin16 = 0.006750535731900671 Ndiscmin17 = 0.008492907883323074 Ndiscmin18 = 0.005428814126101451 Ndiscmin19 = 0.009012105242474025 Ndiscmin20 = 0.007234162738157972 Ndiscmin21 = 0.009884388575647262 Ndiscmin22 = 0.009888038307873177 Ndiscmin23 = 0.005051735398472611 Ndiscmin24 = 0.00600838087819972 Ndiscmax0 = 20.152837352873927 Ndiscmax1 = 18.214743666787744 Ndiscmax2 = 20.92934714052432 Ndiscmax3 = 20.640241168146478 Ndiscmax4 = 19.344532492665966 Ndiscmax5 = 20.387436197023188 Ndiscmax6 = 19.97857833904406 Ndiscmax7 = 19.90713744715372 Ndiscmax8 = 18.28931928618347 Ndiscmax9 = 19.87707865555754 Ndiscmax10 = 20.40164303221915 Ndiscmax11 = 19.425424069386004 Ndiscmax12 = 19.874265143486333 Ndiscmax13 = 18.846054061021363 Ndiscmax14 = 19.824097527898207 Ndiscmax15 = 18.315752933736096 Ndiscmax16 = 20.416984683731744 Ndiscmax17 = 20.419703460186856 Ndiscmax18 = 19.546539750766566 Ndiscmax19 = 19.13025894801059 Ndiscmax20 = 20.898478519982287 Ndiscmax21 = 19.83348197777329 Ndiscmax22 = 20.306961139369356 Ndiscmax23 = 21.45813767565433 Ndiscmax24 = 19.71418860859206 rnew0 = 4.480279310375958e-08 rnew1 = 4.676465477137118e-08 rnew2 = 4.784330031932312e-08 rnew3 = 4.6546148312844955e-08 rnew4 = 3.4469332437264396e-08 rnew5 = 3.9795502438916923e-08 rnew6 = 4.7317894708828246e-08 rnew7 = 3.765158053080215e-08 rnew8 = 4.74267138011301e-08 rnew9 = 4.928998531752508e-08 rnew10 = 4.238588663432016e-08 rnew11 = 4.376729813760019e-08 rnew12 = 3.918695091812361e-08 rnew13 = 4.024077174401112e-08 rnew14 = 3.354586681707423e-08 rnew15 = 4.223724696898597e-08 rnew16 = 4.5350574768434514e-08 rnew17 = 4.1983896914174444e-08 rnew18 = 5.20514150357379e-08 rnew19 = 5.009699331361261e-08 rnew20 = 3.930294009501891e-08 rnew21 = 3.7197690851986807e-08 rnew22 = 4.661852502963033e-08 rnew23 = 4.553650617739203e-08 rnew24 = 3.805157022241973e-08 lnew0 = 0.387735858082638 lnew1 = 0.43031121376731324 lnew2 = 0.40301225899254234 lnew3 = 0.40792585203541476 lnew4 = 0.35676898788287215 lnew5 = 0.38219330584872335 lnew6 = 0.3903293893623847 lnew7 = 0.373774472673396 lnew8 = 0.38945561862100103 lnew9 = 0.39481896841431396 lnew10 = 0.4367254067422667 lnew11 = 0.4142208810943913 lnew12 = 0.3645130819473035 lnew13 = 0.3392428276231182 lnew14 = 0.3243613185047568 lnew15 = 0.3642056586670911 lnew16 = 0.40470551466947413 lnew17 = 0.3230421464889949 lnew18 = 0.3545951299684138 lnew19 = 0.39431590165921865 lnew20 = 0.36804079203713785 lnew21 = 0.3758218317637645 lnew22 = 0.4803409956069459 lnew23 = 0.4143161615993865 lnew24 = 0.40711750344866954  eps = 17 epsphib = 5.5 Ndiscmin=0.008
subckt my_ckt r0 r1 r2 r3 r4 c0 c1 c2 c3 c4
I0 (r0 c0) JART_VCM_1b_VAR eps = 17 epsphib = 5.5 phibn0 = 0.18 phin = 0.1 un = 4e-06 Ndiscmax = Ndiscmax0  Ndiscmin = Ndiscmin0  Ninit = Ndiscmin0  Nplug = 20 a = 2.5e-10 nyo = 20000000000000.0 dWa = 1.35 Rth0 = 15720000.0 rdet = 4.5e-08 rnew = rnew0 lcell = 3 ldet = 0.4 lnew = lnew0  Rtheff_scaling = 0.27 RTiOx = 650 R0 = 719.244 Rthline = 90471.5 alphaline = 0.00392 eps_eff = (eps)*(8.85419e-12) epsphib_eff = (epsphib)*(8.85419e-12)
I1 (r0 c1) JART_VCM_1b_VAR eps = 17 epsphib = 5.5 phibn0 = 0.18 phin = 0.1 un = 4e-06 Ndiscmax = Ndiscmax1  Ndiscmin = Ndiscmin1  Ninit = Ndiscmin1  Nplug = 20 a = 2.5e-10 nyo = 20000000000000.0 dWa = 1.35 Rth0 = 15720000.0 rdet = 4.5e-08 rnew = rnew1 lcell = 3 ldet = 0.4 lnew = lnew1  Rtheff_scaling = 0.27 RTiOx = 650 R0 = 719.244 Rthline = 90471.5 alphaline = 0.00392 eps_eff = (eps)*(8.85419e-12) epsphib_eff = (epsphib)*(8.85419e-12)
I2 (r0 c2) JART_VCM_1b_VAR eps = 17 epsphib = 5.5 phibn0 = 0.18 phin = 0.1 un = 4e-06 Ndiscmax = Ndiscmax2  Ndiscmin = Ndiscmin2  Ninit = Ndiscmin2  Nplug = 20 a = 2.5e-10 nyo = 20000000000000.0 dWa = 1.35 Rth0 = 15720000.0 rdet = 4.5e-08 rnew = rnew2 lcell = 3 ldet = 0.4 lnew = lnew2  Rtheff_scaling = 0.27 RTiOx = 650 R0 = 719.244 Rthline = 90471.5 alphaline = 0.00392 eps_eff = (eps)*(8.85419e-12) epsphib_eff = (epsphib)*(8.85419e-12)
I3 (r0 c3) JART_VCM_1b_VAR eps = 17 epsphib = 5.5 phibn0 = 0.18 phin = 0.1 un = 4e-06 Ndiscmax = Ndiscmax3  Ndiscmin = Ndiscmin3  Ninit = Ndiscmin3  Nplug = 20 a = 2.5e-10 nyo = 20000000000000.0 dWa = 1.35 Rth0 = 15720000.0 rdet = 4.5e-08 rnew = rnew3 lcell = 3 ldet = 0.4 lnew = lnew3  Rtheff_scaling = 0.27 RTiOx = 650 R0 = 719.244 Rthline = 90471.5 alphaline = 0.00392 eps_eff = (eps)*(8.85419e-12) epsphib_eff = (epsphib)*(8.85419e-12)
I4 (r0 c4) JART_VCM_1b_VAR eps = 17 epsphib = 5.5 phibn0 = 0.18 phin = 0.1 un = 4e-06 Ndiscmax = Ndiscmax4  Ndiscmin = Ndiscmin4  Ninit = Ndiscmin4  Nplug = 20 a = 2.5e-10 nyo = 20000000000000.0 dWa = 1.35 Rth0 = 15720000.0 rdet = 4.5e-08 rnew = rnew4 lcell = 3 ldet = 0.4 lnew = lnew4  Rtheff_scaling = 0.27 RTiOx = 650 R0 = 719.244 Rthline = 90471.5 alphaline = 0.00392 eps_eff = (eps)*(8.85419e-12) epsphib_eff = (epsphib)*(8.85419e-12)
I5 (r1 c0) JART_VCM_1b_VAR eps = 17 epsphib = 5.5 phibn0 = 0.18 phin = 0.1 un = 4e-06 Ndiscmax = Ndiscmax5  Ndiscmin = Ndiscmin5  Ninit = Ndiscmin5  Nplug = 20 a = 2.5e-10 nyo = 20000000000000.0 dWa = 1.35 Rth0 = 15720000.0 rdet = 4.5e-08 rnew = rnew5 lcell = 3 ldet = 0.4 lnew = lnew5  Rtheff_scaling = 0.27 RTiOx = 650 R0 = 719.244 Rthline = 90471.5 alphaline = 0.00392 eps_eff = (eps)*(8.85419e-12) epsphib_eff = (epsphib)*(8.85419e-12)
I6 (r1 c1) JART_VCM_1b_VAR eps = 17 epsphib = 5.5 phibn0 = 0.18 phin = 0.1 un = 4e-06 Ndiscmax = Ndiscmax6  Ndiscmin = Ndiscmin6  Ninit = Ndiscmin6  Nplug = 20 a = 2.5e-10 nyo = 20000000000000.0 dWa = 1.35 Rth0 = 15720000.0 rdet = 4.5e-08 rnew = rnew6 lcell = 3 ldet = 0.4 lnew = lnew6  Rtheff_scaling = 0.27 RTiOx = 650 R0 = 719.244 Rthline = 90471.5 alphaline = 0.00392 eps_eff = (eps)*(8.85419e-12) epsphib_eff = (epsphib)*(8.85419e-12)
I7 (r1 c2) JART_VCM_1b_VAR eps = 17 epsphib = 5.5 phibn0 = 0.18 phin = 0.1 un = 4e-06 Ndiscmax = Ndiscmax7  Ndiscmin = Ndiscmin7  Ninit = Ndiscmin7  Nplug = 20 a = 2.5e-10 nyo = 20000000000000.0 dWa = 1.35 Rth0 = 15720000.0 rdet = 4.5e-08 rnew = rnew7 lcell = 3 ldet = 0.4 lnew = lnew7  Rtheff_scaling = 0.27 RTiOx = 650 R0 = 719.244 Rthline = 90471.5 alphaline = 0.00392 eps_eff = (eps)*(8.85419e-12) epsphib_eff = (epsphib)*(8.85419e-12)
I8 (r1 c3) JART_VCM_1b_VAR eps = 17 epsphib = 5.5 phibn0 = 0.18 phin = 0.1 un = 4e-06 Ndiscmax = Ndiscmax8  Ndiscmin = Ndiscmin8  Ninit = Ndiscmin8  Nplug = 20 a = 2.5e-10 nyo = 20000000000000.0 dWa = 1.35 Rth0 = 15720000.0 rdet = 4.5e-08 rnew = rnew8 lcell = 3 ldet = 0.4 lnew = lnew8  Rtheff_scaling = 0.27 RTiOx = 650 R0 = 719.244 Rthline = 90471.5 alphaline = 0.00392 eps_eff = (eps)*(8.85419e-12) epsphib_eff = (epsphib)*(8.85419e-12)
I9 (r1 c4) JART_VCM_1b_VAR eps = 17 epsphib = 5.5 phibn0 = 0.18 phin = 0.1 un = 4e-06 Ndiscmax = Ndiscmax9  Ndiscmin = Ndiscmin9  Ninit = Ndiscmin9  Nplug = 20 a = 2.5e-10 nyo = 20000000000000.0 dWa = 1.35 Rth0 = 15720000.0 rdet = 4.5e-08 rnew = rnew9 lcell = 3 ldet = 0.4 lnew = lnew9  Rtheff_scaling = 0.27 RTiOx = 650 R0 = 719.244 Rthline = 90471.5 alphaline = 0.00392 eps_eff = (eps)*(8.85419e-12) epsphib_eff = (epsphib)*(8.85419e-12)
I10 (r2 c0) JART_VCM_1b_VAR eps = 17 epsphib = 5.5 phibn0 = 0.18 phin = 0.1 un = 4e-06 Ndiscmax = Ndiscmax10  Ndiscmin = Ndiscmin10  Ninit = Ndiscmin10  Nplug = 20 a = 2.5e-10 nyo = 20000000000000.0 dWa = 1.35 Rth0 = 15720000.0 rdet = 4.5e-08 rnew = rnew10 lcell = 3 ldet = 0.4 lnew = lnew10  Rtheff_scaling = 0.27 RTiOx = 650 R0 = 719.244 Rthline = 90471.5 alphaline = 0.00392 eps_eff = (eps)*(8.85419e-12) epsphib_eff = (epsphib)*(8.85419e-12)
I11 (r2 c1) JART_VCM_1b_VAR eps = 17 epsphib = 5.5 phibn0 = 0.18 phin = 0.1 un = 4e-06 Ndiscmax = Ndiscmax11  Ndiscmin = Ndiscmin11  Ninit = Ndiscmin11  Nplug = 20 a = 2.5e-10 nyo = 20000000000000.0 dWa = 1.35 Rth0 = 15720000.0 rdet = 4.5e-08 rnew = rnew11 lcell = 3 ldet = 0.4 lnew = lnew11  Rtheff_scaling = 0.27 RTiOx = 650 R0 = 719.244 Rthline = 90471.5 alphaline = 0.00392 eps_eff = (eps)*(8.85419e-12) epsphib_eff = (epsphib)*(8.85419e-12)
I12 (r2 c2) JART_VCM_1b_VAR eps = 17 epsphib = 5.5 phibn0 = 0.18 phin = 0.1 un = 4e-06 Ndiscmax = Ndiscmax12  Ndiscmin = Ndiscmin12  Ninit = Ndiscmin12  Nplug = 20 a = 2.5e-10 nyo = 20000000000000.0 dWa = 1.35 Rth0 = 15720000.0 rdet = 4.5e-08 rnew = rnew12 lcell = 3 ldet = 0.4 lnew = lnew12  Rtheff_scaling = 0.27 RTiOx = 650 R0 = 719.244 Rthline = 90471.5 alphaline = 0.00392 eps_eff = (eps)*(8.85419e-12) epsphib_eff = (epsphib)*(8.85419e-12)
I13 (r2 c3) JART_VCM_1b_VAR eps = 17 epsphib = 5.5 phibn0 = 0.18 phin = 0.1 un = 4e-06 Ndiscmax = Ndiscmax13  Ndiscmin = Ndiscmin13  Ninit = Ndiscmin13  Nplug = 20 a = 2.5e-10 nyo = 20000000000000.0 dWa = 1.35 Rth0 = 15720000.0 rdet = 4.5e-08 rnew = rnew13 lcell = 3 ldet = 0.4 lnew = lnew13  Rtheff_scaling = 0.27 RTiOx = 650 R0 = 719.244 Rthline = 90471.5 alphaline = 0.00392 eps_eff = (eps)*(8.85419e-12) epsphib_eff = (epsphib)*(8.85419e-12)
I14 (r2 c4) JART_VCM_1b_VAR eps = 17 epsphib = 5.5 phibn0 = 0.18 phin = 0.1 un = 4e-06 Ndiscmax = Ndiscmax14  Ndiscmin = Ndiscmin14  Ninit = Ndiscmin14  Nplug = 20 a = 2.5e-10 nyo = 20000000000000.0 dWa = 1.35 Rth0 = 15720000.0 rdet = 4.5e-08 rnew = rnew14 lcell = 3 ldet = 0.4 lnew = lnew14  Rtheff_scaling = 0.27 RTiOx = 650 R0 = 719.244 Rthline = 90471.5 alphaline = 0.00392 eps_eff = (eps)*(8.85419e-12) epsphib_eff = (epsphib)*(8.85419e-12)
I15 (r3 c0) JART_VCM_1b_VAR eps = 17 epsphib = 5.5 phibn0 = 0.18 phin = 0.1 un = 4e-06 Ndiscmax = Ndiscmax15  Ndiscmin = Ndiscmin15  Ninit = Ndiscmin15  Nplug = 20 a = 2.5e-10 nyo = 20000000000000.0 dWa = 1.35 Rth0 = 15720000.0 rdet = 4.5e-08 rnew = rnew15 lcell = 3 ldet = 0.4 lnew = lnew15  Rtheff_scaling = 0.27 RTiOx = 650 R0 = 719.244 Rthline = 90471.5 alphaline = 0.00392 eps_eff = (eps)*(8.85419e-12) epsphib_eff = (epsphib)*(8.85419e-12)
I16 (r3 c1) JART_VCM_1b_VAR eps = 17 epsphib = 5.5 phibn0 = 0.18 phin = 0.1 un = 4e-06 Ndiscmax = Ndiscmax16  Ndiscmin = Ndiscmin16  Ninit = Ndiscmin16  Nplug = 20 a = 2.5e-10 nyo = 20000000000000.0 dWa = 1.35 Rth0 = 15720000.0 rdet = 4.5e-08 rnew = rnew16 lcell = 3 ldet = 0.4 lnew = lnew16  Rtheff_scaling = 0.27 RTiOx = 650 R0 = 719.244 Rthline = 90471.5 alphaline = 0.00392 eps_eff = (eps)*(8.85419e-12) epsphib_eff = (epsphib)*(8.85419e-12)
I17 (r3 c2) JART_VCM_1b_VAR eps = 17 epsphib = 5.5 phibn0 = 0.18 phin = 0.1 un = 4e-06 Ndiscmax = Ndiscmax17  Ndiscmin = Ndiscmin17  Ninit = Ndiscmin17  Nplug = 20 a = 2.5e-10 nyo = 20000000000000.0 dWa = 1.35 Rth0 = 15720000.0 rdet = 4.5e-08 rnew = rnew17 lcell = 3 ldet = 0.4 lnew = lnew17  Rtheff_scaling = 0.27 RTiOx = 650 R0 = 719.244 Rthline = 90471.5 alphaline = 0.00392 eps_eff = (eps)*(8.85419e-12) epsphib_eff = (epsphib)*(8.85419e-12)
I18 (r3 c3) JART_VCM_1b_VAR eps = 17 epsphib = 5.5 phibn0 = 0.18 phin = 0.1 un = 4e-06 Ndiscmax = Ndiscmax18  Ndiscmin = Ndiscmin18  Ninit = Ndiscmin18  Nplug = 20 a = 2.5e-10 nyo = 20000000000000.0 dWa = 1.35 Rth0 = 15720000.0 rdet = 4.5e-08 rnew = rnew18 lcell = 3 ldet = 0.4 lnew = lnew18  Rtheff_scaling = 0.27 RTiOx = 650 R0 = 719.244 Rthline = 90471.5 alphaline = 0.00392 eps_eff = (eps)*(8.85419e-12) epsphib_eff = (epsphib)*(8.85419e-12)
I19 (r3 c4) JART_VCM_1b_VAR eps = 17 epsphib = 5.5 phibn0 = 0.18 phin = 0.1 un = 4e-06 Ndiscmax = Ndiscmax19  Ndiscmin = Ndiscmin19  Ninit = Ndiscmin19  Nplug = 20 a = 2.5e-10 nyo = 20000000000000.0 dWa = 1.35 Rth0 = 15720000.0 rdet = 4.5e-08 rnew = rnew19 lcell = 3 ldet = 0.4 lnew = lnew19  Rtheff_scaling = 0.27 RTiOx = 650 R0 = 719.244 Rthline = 90471.5 alphaline = 0.00392 eps_eff = (eps)*(8.85419e-12) epsphib_eff = (epsphib)*(8.85419e-12)
I20 (r4 c0) JART_VCM_1b_VAR eps = 17 epsphib = 5.5 phibn0 = 0.18 phin = 0.1 un = 4e-06 Ndiscmax = Ndiscmax20  Ndiscmin = Ndiscmin20  Ninit = Ndiscmin20  Nplug = 20 a = 2.5e-10 nyo = 20000000000000.0 dWa = 1.35 Rth0 = 15720000.0 rdet = 4.5e-08 rnew = rnew20 lcell = 3 ldet = 0.4 lnew = lnew20  Rtheff_scaling = 0.27 RTiOx = 650 R0 = 719.244 Rthline = 90471.5 alphaline = 0.00392 eps_eff = (eps)*(8.85419e-12) epsphib_eff = (epsphib)*(8.85419e-12)
I21 (r4 c1) JART_VCM_1b_VAR eps = 17 epsphib = 5.5 phibn0 = 0.18 phin = 0.1 un = 4e-06 Ndiscmax = Ndiscmax21  Ndiscmin = Ndiscmin21  Ninit = Ndiscmin21  Nplug = 20 a = 2.5e-10 nyo = 20000000000000.0 dWa = 1.35 Rth0 = 15720000.0 rdet = 4.5e-08 rnew = rnew21 lcell = 3 ldet = 0.4 lnew = lnew21  Rtheff_scaling = 0.27 RTiOx = 650 R0 = 719.244 Rthline = 90471.5 alphaline = 0.00392 eps_eff = (eps)*(8.85419e-12) epsphib_eff = (epsphib)*(8.85419e-12)
I22 (r4 c2) JART_VCM_1b_VAR eps = 17 epsphib = 5.5 phibn0 = 0.18 phin = 0.1 un = 4e-06 Ndiscmax = Ndiscmax22  Ndiscmin = Ndiscmin22  Ninit = Ndiscmin22  Nplug = 20 a = 2.5e-10 nyo = 20000000000000.0 dWa = 1.35 Rth0 = 15720000.0 rdet = 4.5e-08 rnew = rnew22 lcell = 3 ldet = 0.4 lnew = lnew22  Rtheff_scaling = 0.27 RTiOx = 650 R0 = 719.244 Rthline = 90471.5 alphaline = 0.00392 eps_eff = (eps)*(8.85419e-12) epsphib_eff = (epsphib)*(8.85419e-12)
I23 (r4 c3) JART_VCM_1b_VAR eps = 17 epsphib = 5.5 phibn0 = 0.18 phin = 0.1 un = 4e-06 Ndiscmax = Ndiscmax23  Ndiscmin = Ndiscmin23  Ninit = Ndiscmin23  Nplug = 20 a = 2.5e-10 nyo = 20000000000000.0 dWa = 1.35 Rth0 = 15720000.0 rdet = 4.5e-08 rnew = rnew23 lcell = 3 ldet = 0.4 lnew = lnew23  Rtheff_scaling = 0.27 RTiOx = 650 R0 = 719.244 Rthline = 90471.5 alphaline = 0.00392 eps_eff = (eps)*(8.85419e-12) epsphib_eff = (epsphib)*(8.85419e-12)
I24 (r4 c4) JART_VCM_1b_VAR eps = 17 epsphib = 5.5 phibn0 = 0.18 phin = 0.1 un = 4e-06 Ndiscmax = Ndiscmax24  Ndiscmin = Ndiscmin24  Ninit = Ndiscmin24  Nplug = 20 a = 2.5e-10 nyo = 20000000000000.0 dWa = 1.35 Rth0 = 15720000.0 rdet = 4.5e-08 rnew = rnew24 lcell = 3 ldet = 0.4 lnew = lnew24  Rtheff_scaling = 0.27 RTiOx = 650 R0 = 719.244 Rthline = 90471.5 alphaline = 0.00392 eps_eff = (eps)*(8.85419e-12) epsphib_eff = (epsphib)*(8.85419e-12)
ends my_ckt
XBAR (r0 r1 r2 r3 r4 c0 c1 c2 c3 c4 ) my_ckt
V0 (r0  0) vsource type=pulse val0=-1.4 val1=1.2 period=200n width=50n rise=25n fall=25n
V1 (r1  0) vsource type=pulse val0=-1.1 val1=1.5 period=145n width=60n rise=35n fall=15n
V2 (r2  0) vsource type=pulse val0=-1.3 val1=1.3 period=146n width=59n rise=34n fall=26n
V3 (r3  0) vsource type=pulse val0=-0.9 val1=1.6 period=147n width=58n rise=33n fall=37n
V4 (r4  0) vsource type=pulse val0=-1.2 val1=1.9 period=148n width=57n rise=32n fall=48n
V5 (c0  0) vsource type=pulse val0=0 val1=0 period=200n width=50n rise=25n fall=25n
V6 (c1  0) vsource type=pulse val0=0 val1=0 period=200n width=50n rise=25n fall=25n
V7 (c2  0) vsource type=pulse val0=0 val1=0 period=200n width=50n rise=25n fall=25n
V8 (c3  0) vsource type=pulse val0=0 val1=0 period=200n width=50n rise=25n fall=25n
V9 (c4  0) vsource type=pulse val0=0 val1=0 period=200n width=50n rise=25n fall=25n

 save XBAR.I0:OE XBAR.I1:OE XBAR.I2:OE XBAR.I3:OE XBAR.I4:OE XBAR.I5:OE XBAR.I6:OE XBAR.I7:OE XBAR.I8:OE XBAR.I9:OE XBAR.I10:OE XBAR.I11:OE XBAR.I12:OE XBAR.I13:OE XBAR.I14:OE XBAR.I15:OE XBAR.I16:OE XBAR.I17:OE XBAR.I18:OE XBAR.I19:OE XBAR.I20:OE XBAR.I21:OE XBAR.I22:OE XBAR.I23:OE XBAR.I24:OE XBAR.I2:AE
ahdl_include "/net/home/zahr/Downloads/counterfeit/JART_VCM_1b_verilog-var.va"
trans tran stop=5u errpreset=conservative maxstep =1u write="spectre.ic" 		writefinal="spectre.fc" annotate=status maxiters=5
saveOptions options save=allpub
