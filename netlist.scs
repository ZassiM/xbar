parameters Ndiscmax0 = 19.091200807638643 Ndiscmax1 = 20.85691831976768 Ndiscmax2 = 20.13433515518676 Ndiscmax3 = 19.587219287412314 Ndiscmax4 = 20.13775311237699 Ndiscmax5 = 19.862388181606157 Ndiscmax6 = 18.455891632863736 Ndiscmax7 = 19.921132796040247 Ndiscmax8 = 22.86639074055113 Ndiscmax9 = 20.3412358268735 Ndiscmax10 = 18.695140379640478 Ndiscmax11 = 21.470895434775592 Ndiscmax12 = 20.399894413257837 Ndiscmax13 = 18.82019204266828 Ndiscmax14 = 19.877547480157975 Ndiscmax15 = 20.680577304549345 Ndiscmax16 = 19.39528550537445 Ndiscmax17 = 21.361164165506743 Ndiscmax18 = 20.3998244827976 Ndiscmax19 = 20.78403772275631 Ndiscmax20 = 20.282267592244832 Ndiscmax21 = 22.13912949115966 Ndiscmax22 = 20.736781768625168 Ndiscmax23 = 19.039678108074394 Ndiscmax24 = 20.66926175169559  eps = 17 epsphib = 5.5 Ndiscmin=0.008
subckt my_ckt r0 r1 r2 r3 r4 c0 c1 c2 c3 c4
I0 (r0 c0) JART_VCM_1b_VAR eps = 17 epsphib = 5.5 phibn0 = 0.18 phin = 0.1 un = 4e-06 Ndiscmax = Ndiscmax0  Ndiscmin = 0.008 Ninit = Ndiscmin Nplug = 20 a = 2.5e-10 nyo = 20000000000000.0 dWa = 1.35 Rth0 = 15720000.0 rdet = 4.5e-08 rnew = 4.5e-08 lcell = 3 ldet = 0.4 lnew = 0.4 Rtheff_scaling = 0.27 RTiOx = 650 R0 = 719.244 Rthline = 90471.5 alphaline = 0.00392 eps_eff = (eps)*(8.85419e-12) epsphib_eff = (epsphib)*(8.85419e-12)
I1 (r0 c1) JART_VCM_1b_VAR eps = 17 epsphib = 5.5 phibn0 = 0.18 phin = 0.1 un = 4e-06 Ndiscmax = Ndiscmax1  Ndiscmin = 0.008 Ninit = Ndiscmin Nplug = 20 a = 2.5e-10 nyo = 20000000000000.0 dWa = 1.35 Rth0 = 15720000.0 rdet = 4.5e-08 rnew = 4.5e-08 lcell = 3 ldet = 0.4 lnew = 0.4 Rtheff_scaling = 0.27 RTiOx = 650 R0 = 719.244 Rthline = 90471.5 alphaline = 0.00392 eps_eff = (eps)*(8.85419e-12) epsphib_eff = (epsphib)*(8.85419e-12)
I2 (r0 c2) JART_VCM_1b_VAR eps = 17 epsphib = 5.5 phibn0 = 0.18 phin = 0.1 un = 4e-06 Ndiscmax = Ndiscmax2  Ndiscmin = 0.008 Ninit = Ndiscmin Nplug = 20 a = 2.5e-10 nyo = 20000000000000.0 dWa = 1.35 Rth0 = 15720000.0 rdet = 4.5e-08 rnew = 4.5e-08 lcell = 3 ldet = 0.4 lnew = 0.4 Rtheff_scaling = 0.27 RTiOx = 650 R0 = 719.244 Rthline = 90471.5 alphaline = 0.00392 eps_eff = (eps)*(8.85419e-12) epsphib_eff = (epsphib)*(8.85419e-12)
I3 (r0 c3) JART_VCM_1b_VAR eps = 17 epsphib = 5.5 phibn0 = 0.18 phin = 0.1 un = 4e-06 Ndiscmax = Ndiscmax3  Ndiscmin = 0.008 Ninit = Ndiscmin Nplug = 20 a = 2.5e-10 nyo = 20000000000000.0 dWa = 1.35 Rth0 = 15720000.0 rdet = 4.5e-08 rnew = 4.5e-08 lcell = 3 ldet = 0.4 lnew = 0.4 Rtheff_scaling = 0.27 RTiOx = 650 R0 = 719.244 Rthline = 90471.5 alphaline = 0.00392 eps_eff = (eps)*(8.85419e-12) epsphib_eff = (epsphib)*(8.85419e-12)
I4 (r0 c4) JART_VCM_1b_VAR eps = 17 epsphib = 5.5 phibn0 = 0.18 phin = 0.1 un = 4e-06 Ndiscmax = Ndiscmax4  Ndiscmin = 0.008 Ninit = Ndiscmin Nplug = 20 a = 2.5e-10 nyo = 20000000000000.0 dWa = 1.35 Rth0 = 15720000.0 rdet = 4.5e-08 rnew = 4.5e-08 lcell = 3 ldet = 0.4 lnew = 0.4 Rtheff_scaling = 0.27 RTiOx = 650 R0 = 719.244 Rthline = 90471.5 alphaline = 0.00392 eps_eff = (eps)*(8.85419e-12) epsphib_eff = (epsphib)*(8.85419e-12)
I5 (r1 c0) JART_VCM_1b_VAR eps = 17 epsphib = 5.5 phibn0 = 0.18 phin = 0.1 un = 4e-06 Ndiscmax = Ndiscmax5  Ndiscmin = 0.008 Ninit = Ndiscmin Nplug = 20 a = 2.5e-10 nyo = 20000000000000.0 dWa = 1.35 Rth0 = 15720000.0 rdet = 4.5e-08 rnew = 4.5e-08 lcell = 3 ldet = 0.4 lnew = 0.4 Rtheff_scaling = 0.27 RTiOx = 650 R0 = 719.244 Rthline = 90471.5 alphaline = 0.00392 eps_eff = (eps)*(8.85419e-12) epsphib_eff = (epsphib)*(8.85419e-12)
I6 (r1 c1) JART_VCM_1b_VAR eps = 17 epsphib = 5.5 phibn0 = 0.18 phin = 0.1 un = 4e-06 Ndiscmax = Ndiscmax6  Ndiscmin = 0.008 Ninit = Ndiscmin Nplug = 20 a = 2.5e-10 nyo = 20000000000000.0 dWa = 1.35 Rth0 = 15720000.0 rdet = 4.5e-08 rnew = 4.5e-08 lcell = 3 ldet = 0.4 lnew = 0.4 Rtheff_scaling = 0.27 RTiOx = 650 R0 = 719.244 Rthline = 90471.5 alphaline = 0.00392 eps_eff = (eps)*(8.85419e-12) epsphib_eff = (epsphib)*(8.85419e-12)
I7 (r1 c2) JART_VCM_1b_VAR eps = 17 epsphib = 5.5 phibn0 = 0.18 phin = 0.1 un = 4e-06 Ndiscmax = Ndiscmax7  Ndiscmin = 0.008 Ninit = Ndiscmin Nplug = 20 a = 2.5e-10 nyo = 20000000000000.0 dWa = 1.35 Rth0 = 15720000.0 rdet = 4.5e-08 rnew = 4.5e-08 lcell = 3 ldet = 0.4 lnew = 0.4 Rtheff_scaling = 0.27 RTiOx = 650 R0 = 719.244 Rthline = 90471.5 alphaline = 0.00392 eps_eff = (eps)*(8.85419e-12) epsphib_eff = (epsphib)*(8.85419e-12)
I8 (r1 c3) JART_VCM_1b_VAR eps = 17 epsphib = 5.5 phibn0 = 0.18 phin = 0.1 un = 4e-06 Ndiscmax = Ndiscmax8  Ndiscmin = 0.008 Ninit = Ndiscmin Nplug = 20 a = 2.5e-10 nyo = 20000000000000.0 dWa = 1.35 Rth0 = 15720000.0 rdet = 4.5e-08 rnew = 4.5e-08 lcell = 3 ldet = 0.4 lnew = 0.4 Rtheff_scaling = 0.27 RTiOx = 650 R0 = 719.244 Rthline = 90471.5 alphaline = 0.00392 eps_eff = (eps)*(8.85419e-12) epsphib_eff = (epsphib)*(8.85419e-12)
I9 (r1 c4) JART_VCM_1b_VAR eps = 17 epsphib = 5.5 phibn0 = 0.18 phin = 0.1 un = 4e-06 Ndiscmax = Ndiscmax9  Ndiscmin = 0.008 Ninit = Ndiscmin Nplug = 20 a = 2.5e-10 nyo = 20000000000000.0 dWa = 1.35 Rth0 = 15720000.0 rdet = 4.5e-08 rnew = 4.5e-08 lcell = 3 ldet = 0.4 lnew = 0.4 Rtheff_scaling = 0.27 RTiOx = 650 R0 = 719.244 Rthline = 90471.5 alphaline = 0.00392 eps_eff = (eps)*(8.85419e-12) epsphib_eff = (epsphib)*(8.85419e-12)
I10 (r2 c0) JART_VCM_1b_VAR eps = 17 epsphib = 5.5 phibn0 = 0.18 phin = 0.1 un = 4e-06 Ndiscmax = Ndiscmax10  Ndiscmin = 0.008 Ninit = Ndiscmin Nplug = 20 a = 2.5e-10 nyo = 20000000000000.0 dWa = 1.35 Rth0 = 15720000.0 rdet = 4.5e-08 rnew = 4.5e-08 lcell = 3 ldet = 0.4 lnew = 0.4 Rtheff_scaling = 0.27 RTiOx = 650 R0 = 719.244 Rthline = 90471.5 alphaline = 0.00392 eps_eff = (eps)*(8.85419e-12) epsphib_eff = (epsphib)*(8.85419e-12)
I11 (r2 c1) JART_VCM_1b_VAR eps = 17 epsphib = 5.5 phibn0 = 0.18 phin = 0.1 un = 4e-06 Ndiscmax = Ndiscmax11  Ndiscmin = 0.008 Ninit = Ndiscmin Nplug = 20 a = 2.5e-10 nyo = 20000000000000.0 dWa = 1.35 Rth0 = 15720000.0 rdet = 4.5e-08 rnew = 4.5e-08 lcell = 3 ldet = 0.4 lnew = 0.4 Rtheff_scaling = 0.27 RTiOx = 650 R0 = 719.244 Rthline = 90471.5 alphaline = 0.00392 eps_eff = (eps)*(8.85419e-12) epsphib_eff = (epsphib)*(8.85419e-12)
I12 (r2 c2) JART_VCM_1b_VAR eps = 17 epsphib = 5.5 phibn0 = 0.18 phin = 0.1 un = 4e-06 Ndiscmax = Ndiscmax12  Ndiscmin = 0.008 Ninit = Ndiscmin Nplug = 20 a = 2.5e-10 nyo = 20000000000000.0 dWa = 1.35 Rth0 = 15720000.0 rdet = 4.5e-08 rnew = 4.5e-08 lcell = 3 ldet = 0.4 lnew = 0.4 Rtheff_scaling = 0.27 RTiOx = 650 R0 = 719.244 Rthline = 90471.5 alphaline = 0.00392 eps_eff = (eps)*(8.85419e-12) epsphib_eff = (epsphib)*(8.85419e-12)
I13 (r2 c3) JART_VCM_1b_VAR eps = 17 epsphib = 5.5 phibn0 = 0.18 phin = 0.1 un = 4e-06 Ndiscmax = Ndiscmax13  Ndiscmin = 0.008 Ninit = Ndiscmin Nplug = 20 a = 2.5e-10 nyo = 20000000000000.0 dWa = 1.35 Rth0 = 15720000.0 rdet = 4.5e-08 rnew = 4.5e-08 lcell = 3 ldet = 0.4 lnew = 0.4 Rtheff_scaling = 0.27 RTiOx = 650 R0 = 719.244 Rthline = 90471.5 alphaline = 0.00392 eps_eff = (eps)*(8.85419e-12) epsphib_eff = (epsphib)*(8.85419e-12)
I14 (r2 c4) JART_VCM_1b_VAR eps = 17 epsphib = 5.5 phibn0 = 0.18 phin = 0.1 un = 4e-06 Ndiscmax = Ndiscmax14  Ndiscmin = 0.008 Ninit = Ndiscmin Nplug = 20 a = 2.5e-10 nyo = 20000000000000.0 dWa = 1.35 Rth0 = 15720000.0 rdet = 4.5e-08 rnew = 4.5e-08 lcell = 3 ldet = 0.4 lnew = 0.4 Rtheff_scaling = 0.27 RTiOx = 650 R0 = 719.244 Rthline = 90471.5 alphaline = 0.00392 eps_eff = (eps)*(8.85419e-12) epsphib_eff = (epsphib)*(8.85419e-12)
I15 (r3 c0) JART_VCM_1b_VAR eps = 17 epsphib = 5.5 phibn0 = 0.18 phin = 0.1 un = 4e-06 Ndiscmax = Ndiscmax15  Ndiscmin = 0.008 Ninit = Ndiscmin Nplug = 20 a = 2.5e-10 nyo = 20000000000000.0 dWa = 1.35 Rth0 = 15720000.0 rdet = 4.5e-08 rnew = 4.5e-08 lcell = 3 ldet = 0.4 lnew = 0.4 Rtheff_scaling = 0.27 RTiOx = 650 R0 = 719.244 Rthline = 90471.5 alphaline = 0.00392 eps_eff = (eps)*(8.85419e-12) epsphib_eff = (epsphib)*(8.85419e-12)
I16 (r3 c1) JART_VCM_1b_VAR eps = 17 epsphib = 5.5 phibn0 = 0.18 phin = 0.1 un = 4e-06 Ndiscmax = Ndiscmax16  Ndiscmin = 0.008 Ninit = Ndiscmin Nplug = 20 a = 2.5e-10 nyo = 20000000000000.0 dWa = 1.35 Rth0 = 15720000.0 rdet = 4.5e-08 rnew = 4.5e-08 lcell = 3 ldet = 0.4 lnew = 0.4 Rtheff_scaling = 0.27 RTiOx = 650 R0 = 719.244 Rthline = 90471.5 alphaline = 0.00392 eps_eff = (eps)*(8.85419e-12) epsphib_eff = (epsphib)*(8.85419e-12)
I17 (r3 c2) JART_VCM_1b_VAR eps = 17 epsphib = 5.5 phibn0 = 0.18 phin = 0.1 un = 4e-06 Ndiscmax = Ndiscmax17  Ndiscmin = 0.008 Ninit = Ndiscmin Nplug = 20 a = 2.5e-10 nyo = 20000000000000.0 dWa = 1.35 Rth0 = 15720000.0 rdet = 4.5e-08 rnew = 4.5e-08 lcell = 3 ldet = 0.4 lnew = 0.4 Rtheff_scaling = 0.27 RTiOx = 650 R0 = 719.244 Rthline = 90471.5 alphaline = 0.00392 eps_eff = (eps)*(8.85419e-12) epsphib_eff = (epsphib)*(8.85419e-12)
I18 (r3 c3) JART_VCM_1b_VAR eps = 17 epsphib = 5.5 phibn0 = 0.18 phin = 0.1 un = 4e-06 Ndiscmax = Ndiscmax18  Ndiscmin = 0.008 Ninit = Ndiscmin Nplug = 20 a = 2.5e-10 nyo = 20000000000000.0 dWa = 1.35 Rth0 = 15720000.0 rdet = 4.5e-08 rnew = 4.5e-08 lcell = 3 ldet = 0.4 lnew = 0.4 Rtheff_scaling = 0.27 RTiOx = 650 R0 = 719.244 Rthline = 90471.5 alphaline = 0.00392 eps_eff = (eps)*(8.85419e-12) epsphib_eff = (epsphib)*(8.85419e-12)
I19 (r3 c4) JART_VCM_1b_VAR eps = 17 epsphib = 5.5 phibn0 = 0.18 phin = 0.1 un = 4e-06 Ndiscmax = Ndiscmax19  Ndiscmin = 0.008 Ninit = Ndiscmin Nplug = 20 a = 2.5e-10 nyo = 20000000000000.0 dWa = 1.35 Rth0 = 15720000.0 rdet = 4.5e-08 rnew = 4.5e-08 lcell = 3 ldet = 0.4 lnew = 0.4 Rtheff_scaling = 0.27 RTiOx = 650 R0 = 719.244 Rthline = 90471.5 alphaline = 0.00392 eps_eff = (eps)*(8.85419e-12) epsphib_eff = (epsphib)*(8.85419e-12)
I20 (r4 c0) JART_VCM_1b_VAR eps = 17 epsphib = 5.5 phibn0 = 0.18 phin = 0.1 un = 4e-06 Ndiscmax = Ndiscmax20  Ndiscmin = 0.008 Ninit = Ndiscmin Nplug = 20 a = 2.5e-10 nyo = 20000000000000.0 dWa = 1.35 Rth0 = 15720000.0 rdet = 4.5e-08 rnew = 4.5e-08 lcell = 3 ldet = 0.4 lnew = 0.4 Rtheff_scaling = 0.27 RTiOx = 650 R0 = 719.244 Rthline = 90471.5 alphaline = 0.00392 eps_eff = (eps)*(8.85419e-12) epsphib_eff = (epsphib)*(8.85419e-12)
I21 (r4 c1) JART_VCM_1b_VAR eps = 17 epsphib = 5.5 phibn0 = 0.18 phin = 0.1 un = 4e-06 Ndiscmax = Ndiscmax21  Ndiscmin = 0.008 Ninit = Ndiscmin Nplug = 20 a = 2.5e-10 nyo = 20000000000000.0 dWa = 1.35 Rth0 = 15720000.0 rdet = 4.5e-08 rnew = 4.5e-08 lcell = 3 ldet = 0.4 lnew = 0.4 Rtheff_scaling = 0.27 RTiOx = 650 R0 = 719.244 Rthline = 90471.5 alphaline = 0.00392 eps_eff = (eps)*(8.85419e-12) epsphib_eff = (epsphib)*(8.85419e-12)
I22 (r4 c2) JART_VCM_1b_VAR eps = 17 epsphib = 5.5 phibn0 = 0.18 phin = 0.1 un = 4e-06 Ndiscmax = Ndiscmax22  Ndiscmin = 0.008 Ninit = Ndiscmin Nplug = 20 a = 2.5e-10 nyo = 20000000000000.0 dWa = 1.35 Rth0 = 15720000.0 rdet = 4.5e-08 rnew = 4.5e-08 lcell = 3 ldet = 0.4 lnew = 0.4 Rtheff_scaling = 0.27 RTiOx = 650 R0 = 719.244 Rthline = 90471.5 alphaline = 0.00392 eps_eff = (eps)*(8.85419e-12) epsphib_eff = (epsphib)*(8.85419e-12)
I23 (r4 c3) JART_VCM_1b_VAR eps = 17 epsphib = 5.5 phibn0 = 0.18 phin = 0.1 un = 4e-06 Ndiscmax = Ndiscmax23  Ndiscmin = 0.008 Ninit = Ndiscmin Nplug = 20 a = 2.5e-10 nyo = 20000000000000.0 dWa = 1.35 Rth0 = 15720000.0 rdet = 4.5e-08 rnew = 4.5e-08 lcell = 3 ldet = 0.4 lnew = 0.4 Rtheff_scaling = 0.27 RTiOx = 650 R0 = 719.244 Rthline = 90471.5 alphaline = 0.00392 eps_eff = (eps)*(8.85419e-12) epsphib_eff = (epsphib)*(8.85419e-12)
I24 (r4 c4) JART_VCM_1b_VAR eps = 17 epsphib = 5.5 phibn0 = 0.18 phin = 0.1 un = 4e-06 Ndiscmax = Ndiscmax24  Ndiscmin = 0.008 Ninit = Ndiscmin Nplug = 20 a = 2.5e-10 nyo = 20000000000000.0 dWa = 1.35 Rth0 = 15720000.0 rdet = 4.5e-08 rnew = 4.5e-08 lcell = 3 ldet = 0.4 lnew = 0.4 Rtheff_scaling = 0.27 RTiOx = 650 R0 = 719.244 Rthline = 90471.5 alphaline = 0.00392 eps_eff = (eps)*(8.85419e-12) epsphib_eff = (epsphib)*(8.85419e-12)
ends my_ckt
XBAR (r0 r1 r2 r3 r4 c0 c1 c2 c3 c4 ) my_ckt
V0 (r0  0) vsource type=pulse val0=-1.4 val1=1.2 period=200n width=50n rise=25n fall=25n
V1 (r1  0) vsource type=pulse val0=-1.1 val1=1.5 period=145n width=60n rise=35n fall=15n
V2 (r2  0) vsource type=pulse val0=-1.3 val1=1.3 period=146n width=59n rise=34n fall=26n
V3 (r3  0) vsource type=pulse val0=-0.9 val1=1.6 period=147n width=58n rise=33n fall=37n
V4 (r4  0) vsource type=pulse val0=-1.2 val1=1.9 period=148n width=57n rise=32n fall=48n
V5 (c0  0) vsource type=pulse val0=0.0 val1=0.0 period=200n width=50n rise=25n fall=25n
V6 (c1  0) vsource type=pulse val0=0.0 val1=0.0 period=200n width=50n rise=25n fall=25n
V7 (c2  0) vsource type=pulse val0=0.0 val1=0.0 period=200n width=50n rise=25n fall=25n
V8 (c3  0) vsource type=pulse val0=0.0 val1=0.0 period=200n width=50n rise=25n fall=25n
V9 (c4  0) vsource type=pulse val0=0.0 val1=0.0 period=200n width=50n rise=25n fall=25n

 save XBAR.I0:OE XBAR.I1:OE XBAR.I2:OE XBAR.I3:OE XBAR.I4:OE XBAR.I5:OE XBAR.I6:OE XBAR.I7:OE XBAR.I8:OE XBAR.I9:OE XBAR.I10:OE XBAR.I11:OE XBAR.I12:OE XBAR.I13:OE XBAR.I14:OE XBAR.I15:OE XBAR.I16:OE XBAR.I17:OE XBAR.I18:OE XBAR.I19:OE XBAR.I20:OE XBAR.I21:OE XBAR.I22:OE XBAR.I23:OE XBAR.I24:OE
ahdl_include "C:\Users\wasso\Desktop\HiWi\Gitlab\xbar\JART_VCM_1b_verilogsooo-var.va"
trans tran stop=5u errpreset=conservative maxstep =1u write="spectre.ic" 		writefinal="spectre.fc" annotate=status maxiters=5
saveOptions options save=allpub
